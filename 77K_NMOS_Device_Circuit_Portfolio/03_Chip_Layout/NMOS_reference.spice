.subckt NMOS_LVT_DRAFT D G S B
M1 D G S B sky130_fd_pr__nfet_01v8_lvt w=1.60u l=0.15u
.ends NMOS_LVT_DRAFT
.end
