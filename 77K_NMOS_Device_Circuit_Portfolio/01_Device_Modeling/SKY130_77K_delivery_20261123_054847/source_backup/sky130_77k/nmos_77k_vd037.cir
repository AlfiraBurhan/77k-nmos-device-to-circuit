77 K NMOS transfer curve
.include "cryo_models/sky130_fd_pr__nfet_01v8_lvt__tt_77k.corner.spice"
.temp -196.15
VD d 0 0.37
VG g 0 0
X1 d g 0 0 sky130_fd_pr__nfet_01v8_lvt l=0.15 w=1.6
.control
set wr_singlescale
set wr_vecnames
dc VG 0 1.85 0.01
let idrain = -i(VD)
wrdata idvg_bsim4_77k_vd037.txt v(g) idrain
quit
.endc
.end
