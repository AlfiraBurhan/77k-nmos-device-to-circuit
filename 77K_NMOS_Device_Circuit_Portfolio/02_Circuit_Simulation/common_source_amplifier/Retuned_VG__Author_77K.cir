Common-source amplifier: Retuned_VG, Author_77K
.include "/content/sky130_77k/cryo_models/sky130_fd_pr__nfet_01v8_lvt__tt_77k.corner.spice"
.option scale=1u
.param mc_mm_switch=0 mc_pr_switch=0
.temp -196.15
VDD supply 0 1.8
RD supply out 9000.0
VG g 0 DC 0.874552181146 AC 1
X1 out g 0 0 sky130_fd_pr__nfet_01v8_lvt l=0.15 w=1.6
.control
set wr_singlescale
set wr_vecnames
op
let supply_current = -i(VDD)
wrdata common_source_op.txt v(g) v(out) supply_current
ac lin 3 1 10
let gain_real = real(v(out)/v(g))
let gain_imag = imag(v(out)/v(g))
wrdata common_source_ac.txt gain_real gain_imag
quit
.endc
.end
